# Ansys Electronics Desktop project, version 2020.2
materials:
  M19_24G: permeability{HUnit=A_per_meter BUnit=tesla curve (0, 0) (22.28, 0.05) (25.46, 0.1) (31.83, 0.15) (47.74, 0.36) (63.66, 0.54) (79.57, 0.65) (159.15, 0.99) (318.3, 1.2) (477.46, 1.28) (636.61, 1.33) (795.77, 1.36) (1591.5, 1.44) (3183, 1.52) (4774.6, 1.58) (6366.1, 1.63) (7957.7, 1.67) (15915, 1.8) (31830, 1.9) (111407, 2) (190984, 2.1) (350138, 2.3) (509292, 2.5)} conductivity=1960000 core_loss_type="Electrical Steel" core_loss_kh=164.2 core_loss_kc=1.3 core_loss_ke=1.72 mass_density=7650
  copper_75C: permeability=0.999991 conductivity=46000000
  XG196/96: permeability{HUnit=A_per_meter BUnit=tesla curve (-690000, 0) (-663114, 0.0487979) (-635338, 0.0975957) (-606628, 0.146394) (-576936, 0.195191) (-546211, 0.243989) (-514397, 0.292787) (-481437, 0.341585) (-447266, 0.390383) (-411817, 0.439181) (-375016, 0.487979) (-333348, 0.541105) (-291679, 0.593468) (-250011, 0.64583) (-208342, 0.698192) (-166674, 0.750554) (-125005, 0.802916) (-83337, 0.855278) (-41668.5, 0.907641) (0, 0.96)} magnetic_coercivity{Magnitude=-690000A_per_meter DirComp1=1 DirComp2=0 DirComp3=0}
  vacuum: permittivity=1
  M19_24G_2DSF0.950: permeability{HUnit=A_per_meter BUnit=tesla curve (0, 0) (22.28, 0.0475014) (25.46, 0.0950016) (31.83, 0.142502) (47.74, 0.342003) (63.66, 0.513004) (79.57, 0.617505) (159.15, 0.94051) (318.3, 1.14002) (477.46, 1.21603) (636.61, 1.26354) (795.77, 1.29205) (1591.5, 1.3681) (3183, 1.4442) (4774.6, 1.5013) (6366.1, 1.5489) (7957.7, 1.587) (15915, 1.711) (31830, 1.807) (111407, 1.907) (190984, 2.007) (350138, 2.207) (509292, 2.407) (2100830, 4.407)} core_loss_type="Electrical Steel" core_loss_kh=172.842 core_loss_kc=1.36842 core_loss_ke=1.76468 mass_density=7650
  XG196/96_2DSF1.000_X: permeability{HUnit=A_per_meter BUnit=tesla curve (-880000, -1.91134497) (-860000, -1.358424663) (-840000, -0.855769839) (-820000, -0.554176944) (-800000, -0.378247755) (-780000, -0.26515042) (-760000, -0.177185826) (-740000, -0.114353973) (-720000, -0.06408849) (-690000, 0) (-663114, 0.0487979) (-635338, 0.0975957) (-606628, 0.146394) (-576936, 0.195191) (-546211, 0.243989) (-514397, 0.292787) (-481437, 0.341585) (-447266, 0.390383) (-411817, 0.439181) (-375016, 0.487979) (-333348, 0.541105) (-291679, 0.593468) (-250011, 0.64583) (-208342, 0.698192) (-166674, 0.750554) (-125005, 0.802916) (-83337, 0.855278) (-41668.5, 0.907641) (0, 0.96)} magnetic_coercivity{Magnitude=-689230.11A_per_meter DirComp1=1 DirComp2=0 DirComp3=0}
  copper: permeability=0.999991 conductivity=58000000 mass_density=8933
  M19_24G_3DSF0.950: permeability{HUnit=A_per_meter BUnit=tesla curve (0, 0) (22.28, 0.05) (25.46, 0.1) (31.83, 0.15) (47.74, 0.36) (63.66, 0.54) (79.57, 0.65) (159.15, 0.99) (318.3, 1.2) (477.46, 1.28) (636.61, 1.33) (795.77, 1.36) (1591.5, 1.44) (3183, 1.52) (4774.6, 1.58) (6366.1, 1.63) (7957.7, 1.67) (15915, 1.8) (31830, 1.9) (111407, 2) (190984, 2.1) (350138, 2.3) (509292, 2.5) (2100830, 4.5)} core_loss_type="Electrical Steel" core_loss_kh=164.2 core_loss_kc=1.3 core_loss_ke=1.72 mass_density=7650 stacking_type=Lamination stacking_factor=0.95 stacking_direction=V(3)
  XG196/96_3DSF1.000_X: permeability=1.10716 magnetic_coercivity{Magnitude=-690000A_per_meter DirComp1=1 DirComp2=0 DirComp3=0}

design Maxwell2DDesign1 (Maxwell 2D, Transient, XY geometry, model units mm)
options: ComputeTransientInductance ModelDepth=65mm
variables:
  fractions = 1
  delta = 30.868839deg
  conds = 52
  R1 = 0.65001106ohm
  Le1 = -3.1157849e-05H
geometry:
  Band [vacuum] = user_primitive(RMxprt/Band, DiaGap=74.5mm, DiaYoke=26mm, Length=0mm, SegAngle=0deg, Fractions=1, HalfAxial=0, InfoCore=0)
  Shaft [M19_24G_2DSF0.950] = user_primitive(RMxprt/Band, DiaGap=74.5mm, DiaYoke=26mm, Length=0mm, SegAngle=0deg, Fractions=1, HalfAxial=0, InfoCore=100)
  OuterRegion [vacuum] = user_primitive(RMxprt/Band, DiaGap=74.5mm, DiaYoke=120mm, Length=0mm, SegAngle=0deg, Fractions=fractions, HalfAxial=0, InfoCore=100)
  Tool = user_primitive(RMxprt/Band, DiaGap=74.5mm, DiaYoke=120mm, Length=0mm, SegAngle=0deg, Fractions=fractions, HalfAxial=0, InfoCore=1)
  Stator [M19_24G_2DSF0.950] = user_primitive(RMxprt/SlotCore, DiaGap=75mm, DiaYoke=120mm, Length=0mm, Skew=0deg, Slots=12, SlotType=2, Hs0=0.5mm, Hs01=0mm, Hs1=1mm, Hs2=8.2mm, Bs0=2.5mm, Bs1=5.6mm, Bs2=7.6mm, Rs=3.8mm, FilletType=0, HalfSlot=0, SegAngle=15deg, LenRegion=0mm, InfoCore=0)
  Coil_0 [copper_75C] = user_primitive(RMxprt/LapCoil, DiaGap=75mm, DiaYoke=120mm, Length=0mm, Skew=0deg, Slots=12, SlotType=2, Hs0=0.5mm, Hs1=1mm, Hs2=8.2mm, Bs0=2.5mm, Bs1=5.6mm, Bs2=7.6mm, Rs=3.8mm, FilletType=0, Layers=1, CoilPitch=2, EndExt=0mm, SpanExt=0mm, BendAngle=0deg, SegAngle=10deg, LenRegion=0mm, InfoCoil=2)
  Coil_1..Coil_11 [copper_75C] = Coil_0.duplicate_around_axis(axis=Z, angle=30deg, total=12)
  Rotor [M19_24G_2DSF0.950] = user_primitive(RMxprt/IPMCore, DiaGap=74mm, DiaYoke=26mm, Length=0mm, Poles=10, PoleType=3, D1=72mm, O1=1mm, O2=10mm, B1=2mm, Rib=2mm, HRib=1mm, DminMag=0mm, ThickMag=3mm, WidthMag=20mm, LenRegion=0mm, InfoCore=0)
  Rotor.rotate(axis=Z, angle=18deg)
  coordinate_system relativeCS1_0 = origin=(0, 0, 0) x=(0.86142954, -0.5078771, 0) y=(0.5078771, 0.86142954, 0)
  Mag1_0 [XG196/96_2DSF1.000_X, oriented by relativeCS1_0] = user_primitive(RMxprt/IPMCore, DiaGap=74mm, DiaYoke=26mm, Length=0mm, Poles=10, PoleType=3, D1=72mm, O1=1mm, O2=10mm, B1=2mm, Rib=2mm, HRib=1mm, DminMag=0mm, ThickMag=3mm, WidthMag=20mm, LenRegion=0mm, InfoCore=-1)
  Mag1_0.rotate(axis=Z, angle=18deg)
  Mag1_1 [XG196/96_2DSF1.000_X, oriented by relativeCS1_1], Mag1_2 [XG196/96_2DSF1.000_X, oriented by relativeCS1_2], Mag1_3 [XG196/96_2DSF1.000_X, oriented by relativeCS1_3], Mag1_4 [XG196/96_2DSF1.000_X, oriented by relativeCS1_4], Mag1_5 [XG196/96_2DSF1.000_X, oriented by relativeCS1_5], Mag1_6 [XG196/96_2DSF1.000_X, oriented by relativeCS1_6], Mag1_7 [XG196/96_2DSF1.000_X, oriented by relativeCS1_7], Mag1_8 [XG196/96_2DSF1.000_X, oriented by relativeCS1_8], Mag1_9 [XG196/96_2DSF1.000_X, oriented by relativeCS1_9] = Mag1_0.duplicate_around_axis(axis=Z, angle=36deg, total=10)
  coordinate_system relativeCS1_1 = origin=(0, 0, 0) x=(-0.99543381, -0.095454373, 0) y=(0.095454373, -0.99543381, 0)
  coordinate_system relativeCS1_2 = origin=(0, 0, 0) x=(0.74921619, 0.66232552, 0) y=(-0.66232552, 0.74921619, 0)
  coordinate_system relativeCS1_3 = origin=(0, 0, 0) x=(-0.21682346, -0.97621083, 0) y=(0.97621083, -0.21682346, 0)
  coordinate_system relativeCS1_4 = origin=(0, 0, 0) x=(-0.39838847, 0.91721678, 0) y=(-0.91721678, -0.39838847, 0)
  coordinate_system relativeCS1_5 = origin=(0, 0, 0) x=(0.86142954, -0.5078771, 0) y=(0.5078771, 0.86142954, 0)
  coordinate_system relativeCS1_6 = origin=(0, 0, 0) x=(-0.99543381, -0.095454373, 0) y=(0.095454373, -0.99543381, 0)
  coordinate_system relativeCS1_7 = origin=(0, 0, 0) x=(0.74921619, 0.66232552, 0) y=(-0.66232552, 0.74921619, 0)
  coordinate_system relativeCS1_8 = origin=(0, 0, 0) x=(-0.21682346, -0.97621083, 0) y=(0.97621083, -0.21682346, 0)
  coordinate_system relativeCS1_9 = origin=(0, 0, 0) x=(-0.39838847, 0.91721678, 0) y=(-0.91721678, -0.39838847, 0)
  coordinate_system relativeCS2_0 = origin=(0, 0, 0) x=(0.39838847, 0.91721678, 0) y=(-0.91721678, 0.39838847, 0)
  Mag2_0 [XG196/96_2DSF1.000_X, oriented by relativeCS2_0] = user_primitive(RMxprt/IPMCore, DiaGap=74mm, DiaYoke=26mm, Length=0mm, Poles=10, PoleType=3, D1=72mm, O1=1mm, O2=10mm, B1=2mm, Rib=2mm, HRib=1mm, DminMag=0mm, ThickMag=3mm, WidthMag=20mm, LenRegion=0mm, InfoCore=-2)
  Mag2_0.rotate(axis=Z, angle=18deg)
  Mag2_1 [XG196/96_2DSF1.000_X, oriented by relativeCS2_1], Mag2_2 [XG196/96_2DSF1.000_X, oriented by relativeCS2_2], Mag2_3 [XG196/96_2DSF1.000_X, oriented by relativeCS2_3], Mag2_4 [XG196/96_2DSF1.000_X, oriented by relativeCS2_4], Mag2_5 [XG196/96_2DSF1.000_X, oriented by relativeCS2_5], Mag2_6 [XG196/96_2DSF1.000_X, oriented by relativeCS2_6], Mag2_7 [XG196/96_2DSF1.000_X, oriented by relativeCS2_7], Mag2_8 [XG196/96_2DSF1.000_X, oriented by relativeCS2_8], Mag2_9 [XG196/96_2DSF1.000_X, oriented by relativeCS2_9] = Mag2_0.duplicate_around_axis(axis=Z, angle=36deg, total=10)
  coordinate_system relativeCS2_1 = origin=(0, 0, 0) x=(0.21682346, -0.97621083, 0) y=(0.97621083, 0.21682346, 0)
  coordinate_system relativeCS2_2 = origin=(0, 0, 0) x=(-0.74921619, 0.66232552, 0) y=(-0.66232552, -0.74921619, 0)
  coordinate_system relativeCS2_3 = origin=(0, 0, 0) x=(0.99543381, -0.095454373, 0) y=(0.095454373, 0.99543381, 0)
  coordinate_system relativeCS2_4 = origin=(0, 0, 0) x=(-0.86142954, -0.5078771, 0) y=(0.5078771, -0.86142954, 0)
  coordinate_system relativeCS2_5 = origin=(0, 0, 0) x=(0.39838847, 0.91721678, 0) y=(-0.91721678, 0.39838847, 0)
  coordinate_system relativeCS2_6 = origin=(0, 0, 0) x=(0.21682346, -0.97621083, 0) y=(0.97621083, 0.21682346, 0)
  coordinate_system relativeCS2_7 = origin=(0, 0, 0) x=(-0.74921619, 0.66232552, 0) y=(-0.66232552, -0.74921619, 0)
  coordinate_system relativeCS2_8 = origin=(0, 0, 0) x=(0.99543381, -0.095454373, 0) y=(0.095454373, 0.99543381, 0)
  coordinate_system relativeCS2_9 = origin=(0, 0, 0) x=(-0.86142954, -0.5078771, 0) y=(0.5078771, -0.86142954, 0)
  InnerRegion [vacuum] = user_primitive(RMxprt/IPMCore, DiaGap=74mm, DiaYoke=26mm, Length=0mm, Poles=10, PoleType=3, D1=72mm, O1=1mm, O2=10mm, B1=2mm, Rib=2mm, HRib=1mm, DminMag=0mm, ThickMag=3mm, WidthMag=20mm, LenRegion=0mm, InfoCore=100)
  InnerRegion.rotate(axis=Z, angle=18deg)
  Tool_1 = Tool.copy()
  Band.subtract(Tool_1)
  Tool_2 = Tool.copy()
  InnerRegion.subtract(Tool_2)
  Tool_3 = Tool.copy()
  Shaft.subtract(Tool_3)
  Tool_4 = Tool.copy()
  Stator.subtract(Tool_4)
  Tool_5 = Tool.copy()
  Coil_0.subtract(Tool_5)
  Tool_6 = Tool.copy()
  Coil_1.subtract(Tool_6)
  Tool_7 = Tool.copy()
  Coil_2.subtract(Tool_7)
  Tool_8 = Tool.copy()
  Coil_3.subtract(Tool_8)
  Tool_9 = Tool.copy()
  Coil_4.subtract(Tool_9)
  Tool_10 = Tool.copy()
  Coil_5.subtract(Tool_10)
  Tool_11 = Tool.copy()
  Coil_6.subtract(Tool_11)
  Tool_12 = Tool.copy()
  Coil_7.subtract(Tool_12)
  Tool_13 = Tool.copy()
  Coil_8.subtract(Tool_13)
  Tool_14 = Tool.copy()
  Coil_9.subtract(Tool_14)
  Tool_15 = Tool.copy()
  Coil_10.subtract(Tool_15)
  Tool_16 = Tool.copy()
  Coil_11.subtract(Tool_16)
  Tool_17 = Tool.copy()
  Rotor.subtract(Tool_17)
  Tool_18 = Tool.copy()
  Mag1_0.subtract(Tool_18)
  Tool_19 = Tool.copy()
  Mag1_1.subtract(Tool_19)
  Tool_20 = Tool.copy()
  Mag1_2.subtract(Tool_20)
  Tool_21 = Tool.copy()
  Mag1_3.subtract(Tool_21)
  Tool_22 = Tool.copy()
  Mag1_4.subtract(Tool_22)
  Tool_23 = Tool.copy()
  Mag1_5.subtract(Tool_23)
  Tool_24 = Tool.copy()
  Mag1_6.subtract(Tool_24)
  Tool_25 = Tool.copy()
  Mag1_7.subtract(Tool_25)
  Tool_26 = Tool.copy()
  Mag1_8.subtract(Tool_26)
  Tool_27 = Tool.copy()
  Mag1_9.subtract(Tool_27)
  Tool_28 = Tool.copy()
  Mag2_0.subtract(Tool_28)
  Tool_29 = Tool.copy()
  Mag2_1.subtract(Tool_29)
  Tool_30 = Tool.copy()
  Mag2_2.subtract(Tool_30)
  Tool_31 = Tool.copy()
  Mag2_3.subtract(Tool_31)
  Tool_32 = Tool.copy()
  Mag2_4.subtract(Tool_32)
  Tool_33 = Tool.copy()
  Mag2_5.subtract(Tool_33)
  Tool_34 = Tool.copy()
  Mag2_6.subtract(Tool_34)
  Tool_35 = Tool.copy()
  Mag2_7.subtract(Tool_35)
  Tool_36 = Tool.copy()
  Mag2_8.subtract(Tool_36)
  Mag2_9.subtract(Tool)
  Circle1 [XG196/96_2DSF1.000_X] = circle(normal=Z, centre=(25.833734mm, 13.58333mm, 0mm), radius=0.1mm)
  coordinate_system RelativeCS1 = origin=(0mm, 0mm, 0mm) x=(25.833734mm, 13.58333mm, 0mm) y=(-13.58333mm, 25.833734mm, 0mm)
  coordinate_system ObjectCS1 = object of Mag1_0: Origin=Mag1_0.vertex(1 of 4) xAxisPos=Mag1_0.vertex(4 of 4) yAxis{xDirection=0.5078771 yDirection=0.86142954 zDirection=0} in RelativeCS1
motion:
  MotionSetup1: Band Move_Type=Rotate Coordinate_System=Global Axis=Z Is_Positive=true InitPos=18deg Angular_Velocity=3600rpm Objects=Band
  Moving1: Moving Objects=[Shaft, Rotor, Mag1_0..Mag1_9, Mag2_0..Mag2_9, InnerRegion, Circle1]
boundaries and excitations:
  VectorPotential1: Vector Potential Edges=OuterRegion.edge(at (0, 60, 0)) Value=0
  PhARe_0: Coil Objects=Coil_11 Conductor_number=conds Winding=PhaseA PolarityType=Negative
  PhA_0: Coil Objects=Coil_0 Conductor_number=conds Winding=PhaseA PolarityType=Positive
  PhB_1: Coil Objects=Coil_1 Conductor_number=conds Winding=PhaseB PolarityType=Positive
  PhBRe_1: Coil Objects=Coil_2 Conductor_number=conds Winding=PhaseB PolarityType=Negative
  PhCRe_2: Coil Objects=Coil_3 Conductor_number=conds Winding=PhaseC PolarityType=Negative
  PhC_2: Coil Objects=Coil_4 Conductor_number=conds Winding=PhaseC PolarityType=Positive
  PhA_3: Coil Objects=Coil_5 Conductor_number=conds Winding=PhaseA PolarityType=Positive
  PhARe_3: Coil Objects=Coil_6 Conductor_number=conds Winding=PhaseA PolarityType=Negative
  PhBRe_4: Coil Objects=Coil_7 Conductor_number=conds Winding=PhaseB PolarityType=Negative
  PhB_4: Coil Objects=Coil_8 Conductor_number=conds Winding=PhaseB PolarityType=Positive
  PhC_5: Coil Objects=Coil_9 Conductor_number=conds Winding=PhaseC PolarityType=Positive
  PhCRe_5: Coil Objects=Coil_10 Conductor_number=conds Winding=PhaseC PolarityType=Negative
  PhaseA: Winding Group Type=Voltage IsSolid=false Current=0A Resistance=R1 Inductance=Le1 Voltage=179.629*sin(2*pi*300*time+delta) ParallelBranchesNum=1
  PhaseB: Winding Group Type=Voltage IsSolid=false Current=0A Resistance=R1 Inductance=Le1 Voltage=179.629*sin(2*pi*300*time+delta-2*pi/3) ParallelBranchesNum=1
  PhaseC: Winding Group Type=Voltage IsSolid=false Current=0A Resistance=R1 Inductance=Le1 Voltage=179.629*sin(2*pi*300*time+delta-4*pi/3) ParallelBranchesNum=1
  Y connection: PhaseA, PhaseB, PhaseC
mesh:
  SurfApprox_Mag: SurfApproxBased Objects=[Mag1_0..Mag1_9, Mag2_0..Mag2_9] CurvedSurfaceApproxChoice=ManualSettings SurfDev=0.037mm NormalDev=15deg
  SurfApprox_Main: SurfApproxBased Objects=[Stator, Rotor, Band, OuterRegion, InnerRegion, Shaft] CurvedSurfaceApproxChoice=ManualSettings SurfDev=0.06mm NormalDev=15deg
  initial mesh: MeshMethod=AnsoftTAU
setups:
  Setup1: Transient NonlinearSolverResidual=0.0001 StopTime=3333.333us TimeStep=30us FastReachSteadyState AutoDetectSteadyState FrequencyOfAddedVoltageSource=300Hz StopCriterion=0.005 SaveFieldsType=Custom SweepRanges{0us to 3333.333us step 30us point 3333.333us} NumberSolveSteps=1 RangeStart=0s RangeEnd=0.1s InitialTimeStep=0.002s MinTimeStep=0.001s MaxTimeStep=0.003s TimeStepErrTolerance=0.0001
output variables:
  pos = (Moving1.Position -18 * PI/180) * 5 + PI
  cos0 = cos(pos)
  cos1 = cos(pos-2*PI/3)
  cos2 = cos(pos-4*PI/3)
  sin0 = sin(pos)
  sin1 = sin(pos-2*PI/3)
  sin2 = sin(pos-4*PI/3)
  Lad = L(PhaseA,PhaseA)*cos0 + L(PhaseA,PhaseB)*cos1 + L(PhaseA,PhaseC)*cos2
  Laq = L(PhaseA,PhaseA)*sin0 + L(PhaseA,PhaseB)*sin1 + L(PhaseA,PhaseC)*sin2
  Lbd = L(PhaseB,PhaseA)*cos0 + L(PhaseB,PhaseB)*cos1 + L(PhaseB,PhaseC)*cos2
  Lbq = L(PhaseB,PhaseA)*sin0 + L(PhaseB,PhaseB)*sin1 + L(PhaseB,PhaseC)*sin2
  Lcd = L(PhaseC,PhaseA)*cos0 + L(PhaseC,PhaseB)*cos1 + L(PhaseC,PhaseC)*cos2
  Lcq = L(PhaseC,PhaseA)*sin0 + L(PhaseC,PhaseB)*sin1 + L(PhaseC,PhaseC)*sin2
  L_d = (Lad*cos0 + Lbd*cos1 + Lcd*cos2) * 2/3
  L_q = (Laq*sin0 + Lbq*sin1 + Lcq*sin2) * 2/3
  Flux_d = (FluxLinkage(PhaseA)*cos0+FluxLinkage(PhaseB)*cos1+FluxLinkage(PhaseC)*cos2)*2/3
  Flux_q = (FluxLinkage(PhaseA)*sin0+FluxLinkage(PhaseB)*sin1+FluxLinkage(PhaseC)*sin2)*2/3
  I_d = (Current(PhaseA)*cos0 + Current(PhaseB)*cos1 + Current(PhaseC)*cos2)*2/3
  I_q = (Current(PhaseA)*sin0 + Current(PhaseB)*sin1 + Current(PhaseC)*sin2)*2/3
  Irms = sqrt(I_d^2+I_q^2)/sqrt(2)
  Pcu = 3*Irms^2*R1
field calculator expressions:
  B_radial = Fundamental_Quantity(22) | Vector_Function(FuncValueX='0mm', FuncValueY='0mm', FuncValueZ='0mm') | ToCylindrical | ScalarX
  B_tang = Fundamental_Quantity(22) | Vector_Function(FuncValueX='0mm', FuncValueY='0mm', FuncValueZ='0mm') | ToCylindrical | ScalarY
  H_radial = Fundamental_Quantity(21) | Vector_Function(FuncValueX='0mm', FuncValueY='0mm', FuncValueZ='0mm') | ToCylindrical | ScalarX
  H_tang = Fundamental_Quantity(21) | Vector_Function(FuncValueX='0mm', FuncValueY='0mm', FuncValueZ='0mm') | ToCylindrical | ScalarY
  Surface_detection_circle = 1 | EnterSurface(Circle1) | SurfaceValue | Integrate
  Cosine_1 = EnterCoord(RelativeCS1) | UnitVecCSX | EnterCoord(ObjectCS1) | UnitVecCSX | Dot
  Sine_1 = EnterCoord(RelativeCS1) | UnitVecCSY | EnterCoord(ObjectCS1) | UnitVecCSX | Dot
  B_1 = B_radial | Cosine_1 | * | B_tang | Sine_1 | * | + | EnterSurface(Circle1) | SurfaceValue | Integrate | Surface_detection_circle | /
  H_1 = H_radial | Cosine_1 | * | H_tang | Sine_1 | * | + | EnterSurface(Circle1) | SurfaceValue | Integrate | Surface_detection_circle | /
field plots:
  B_Vector1: B over Band, Shaft, OuterRegion, Stator, Coil_0..Coil_11, Rotor, Mag1_0..Mag1_9, Mag2_0..Mag2_9, InnerRegion, Circle1 on Setup1 : Transient at Time=-1
  Mag_H1: H over Band, Shaft, OuterRegion, Stator, Coil_0..Coil_11, Rotor, Mag1_0..Mag1_9, Mag2_0..Mag2_9, InnerRegion, Circle1 on Setup1 : Transient at Time=-1
reports:
  Stator Currents: Current(PhaseA), Current(PhaseB), Current(PhaseC) vs Time on Setup1 : Transient
  Torque: Moving1.Torque vs Time on Setup1 : Transient
  L_dq: L_d, L_q vs Time on Setup1 : Transient
  Flux_dq: Flux_d, Flux_q vs Time on Setup1 : Transient
  I_dq: I_d, I_q vs Time on Setup1 : Transient
  recoil_curve: Y Component 1 vs Primary Sweep; B_1 vs H_1

design RMxprtDesign1 (RMxprt, Generic Rotating Machines, model units mm)
machine:
  Machine: RotorType=10 StatorType=0 SourceType=0 Structure=0 ImportRotor=0 ImportStator=0 StatorCenter=0 RotorCenter=0 ImportType MasterSlaveOnXais Fraction=0 AirGapLength=0mm DoubleSided=0
  Stator: NumberOfPoles=4 NumberOfSlots=12 SlotType=2 CircuitType=0
  Shaft: MagneticShaft FrictionLoss=0W WindLoss=0W ReferenceSpeed=3600rpm
  Rotor: NumberOfPoles=4
  Stator Core: OuterDiameter=120mm InnerDiameter=75mm Length=65mm SteelType=M19_24G StackingFactor=0.95 LaminationSectors=0 PressBoardThickness=0mm SkewWidth=0deg
  Stator Winding: WindingType=Whole-Coiled WindingLayers=1 ParallelBranches=1 ConductorsPerSlot=52 CoilPitch=5 EndAdjustment=0mm BaseInnerRadius=0mm TipInnerDiameter=0mm EndClearance=0mm CoilWrap=0mm SlotLiner=0.3mm WedgeThickness=0mm LayerInsulation=0mm BottomInsulation=0mm LimitedFillFactor=0.75 WdgNumberofPriodicMultipler=1 WdgConstantTurns Wdgcoil_turns(52, 52, 52, 52, 52, 52) Wdgcoil_name(A, -C, B, A, -C, B) Wdgcoil_go(1, 2, 5, 6, 8, 10) Wdgcoil_re(12, 3, 4, 7, 9, 11) NumberOfStrands=1 WireWrap=0mm InterturnInsulation=0mm WireDiameter=0mm WireWidth=0mm WireThickness=0mm Gauge=0 CorrectionFactor=1 TopSpareSpace=0 BottomSpareSpace=0 ConductorType=copper_75C
  Rotor Core: OuterDiameter=74mm InnerDiameter=26mm Length=65mm SteelType=M19_24G StackingFactor=0.95 PoleType=3
  Core Slot: Hs0=0.5mm Hs1=1mm Hs2=8.2mm Bs0=2.5mm Bs1=5.6mm Bs2=7.6mm Rs=0mm ToothWidth=0mm
  Core Pole: D1=72mm O1=3mm O2=3mm B1=2mm Rib=2mm HRib=1mm Layers=1 LayerPitch=0mm MagnetThickness=3mm MagnetWidth=45mm MagnetType=XG196/96
setups:
  Setup1: GRM Motor RatedOutputPower=0.55kW RatedVoltage=220V RatedSpeed=3600rpm OperatingTemperature=75cel LoadType=ConstPower RatedPowerFactor=0.8 Frequency=60Hz
