# Ansys Electronics Desktop project, version 2020.2
materials:
  M19_24G_2DSF0.950: permeability{HUnit=A_per_meter BUnit=tesla curve (0, 0) (22.28, 0.0475014) (25.46, 0.0950016) (31.83, 0.142502) (47.74, 0.342003) (63.66, 0.513004) (79.57, 0.617505) (159.15, 0.94051) (318.3, 1.14002) (477.46, 1.21603) (636.61, 1.26354) (795.77, 1.29205) (1591.5, 1.3681) (3183, 1.4442) (4774.6, 1.5013) (6366.1, 1.5489) (7957.7, 1.587) (15915, 1.711) (31830, 1.807) (111407, 1.907) (190984, 2.007) (350138, 2.207) (509292, 2.407) (2100830, 4.407)} core_loss_type="Electrical Steel" core_loss_kh=172.842 core_loss_kc=1.36842 core_loss_ke=1.76468 mass_density=7650
  XG196/96: permeability{HUnit=A_per_meter BUnit=tesla curve (-880000, -1.91134497) (-860000, -1.358424663) (-840000, -0.855769839) (-820000, -0.554176944) (-800000, -0.378247755) (-780000, -0.26515042) (-760000, -0.177185826) (-740000, -0.114353973) (-720000, -0.06408849) (-690000, 0) (-663114, 0.0487979) (-635338, 0.0975957) (-606628, 0.146394) (-576936, 0.195191) (-546211, 0.243989) (-514397, 0.292787) (-481437, 0.341585) (-447266, 0.390383) (-411817, 0.439181) (-375016, 0.487979) (-333348, 0.541105) (-291679, 0.593468) (-250011, 0.64583) (-208342, 0.698192) (-166674, 0.750554) (-125005, 0.802916) (-83337, 0.855278) (-41668.5, 0.907641) (0, 0.96)} magnetic_coercivity{Magnitude=-689230.11A_per_meter DirComp1=1 DirComp2=0 DirComp3=0}
  copper_75C: permeability=0.999991 conductivity=46000000
  vacuum: permittivity=1
  VACODYM 633AP  20Â°C: permeability{HUnit=A_per_meter BUnit=tesla curve (-1511972, -1.9) (-1508932.1, -1.81316) (-1505900.2, -1.72632) (-1502860.3, -1.63947) (-1499820.5, -1.55263) (-1496788.6, -1.46579) (-1493748.7, -1.37895) (-1490708.9, -1.2921) (-1487677, -1.20526) (-1484637.1, -1.11842) (-1481597.2, -1.03158) (-1477690, -0.935463) (-1473790.7, -0.865327) (-1469883.4, -0.813935) (-1465976.2, -0.775376) (-1462068.9, -0.745542) (-1458169.6, -0.721724) (-1454262.4, -0.702152) (-1450355.1, -0.685651) (-1446455.8, -0.671427) (-1442548.6, -0.658928) (-1435601.5, -0.639817) (-1428662.3, -0.623525) (-1421723.1, -0.609179) (-1414776, -0.59623) (-1407836.9, -0.584316) (-1400889.8, -0.573187) (-1393950.6, -0.562669) (-1387003.5, -0.552635) (-1380064.3, -0.542992) (-1373125.2, -0.532926) (-1235806.3, -0.352134) (-1098495.4, -0.171341) (-968362.34, 0) (-961184.45, 0.00945162) (-823873.52, 0.190244) (-686561, 0.371037) (-549248.48, 0.551829) (-411936.76, 0.732622) (-274624.24, 0.913415) (-137312.52, 1.09421) (0, 1.275)} conductivity=714286 magnetic_coercivity{Magnitude=-968362.59A_per_meter DirComp1=1 DirComp2=0 DirComp3=0}
  NdFe35: permittivity=1 permeability{HUnit=A_per_meter BUnit=tesla curve (-1000000, -2.56666667) (-995000, -2.53458333) (-990000, -2.5025) (-985000, -2.47041667) (-980000, -2.43833333) (-975000, -2.40625) (-970000, -2.37416667) (-965000, -2.34208333) (-960000, -2.31) (-955000, -2.27791667) (-950000, -2.24583333) (-945000, -2.21375) (-940000, -2.18166667) (-935000, -2.14958333) (-930000, -2.1175) (-925000, -2.08541667) (-920000, -2.05333333) (-915000, -2.02125) (-910000, -1.98916667) (-905000, -1.95708333) (-900000, -1.925) (-895000, -1.89291667) (-890000, -1.86083333) (-885000, -1.82875) (-880000, -1.79666667) (-875000, -1.76458333) (-870000, -1.7325) (-865000, -1.70041667) (-860000, -1.66833333) (-855000, -1.63625) (-850000, -1.60416667) (-845000, -1.57208333) (-840000, -1.54) (-835000, -1.50791667) (-830000, -1.47583333) (-825000, -1.44375) (-820000, -1.41166667) (-815000, -1.37958333) (-810000, -1.3475) (-805000, -1.31541667) (-800000, -1.28333333) (-795000, -1.25125) (-790000, -1.21916667) (-785000, -1.18708333) (-780000, -1.155) (-775000, -1.12291667) (-770000, -1.09083333) (-765000, -1.05875) (-760000, -1.02666667) (-755000, -0.99458333) (-750000, -0.9625) (-745000, -0.93041667) (-740000, -0.89833333) (-735000, -0.86625) (-730000, -0.83416667) (-725000, -0.80208333) (-720000, -0.77) (-715000, -0.73791667) (-710000, -0.70583333) (-705000, -0.67375) (-700000, -0.64166667) (-695000, -0.60958333) (-690000, -0.5775) (-685000, -0.54541667) (-680000, -0.51333333) (-675000, -0.48125) (-670000, -0.44916667) (-665000, -0.41708333) (-660000, -0.385) (-655000, -0.35291667) (-650000, -0.32083333) (-645000, -0.28875) (-640000, -0.25666667) (-635000, -0.22458333) (-630000, -0.1925) (-625000, -0.16041667) (-620000, -0.12833333) (-615000, -0.09625) (-610000, -0.06416667) (-605000, -0.03208333) (-600000, 0) (-595000, 0.03194444) (-590000, 0.06268849) (-585000, 0.09223214) (-580000, 0.1205754) (-575000, 0.14771825) (-570000, 0.17366071) (-565000, 0.19840278) (-560000, 0.22194444) (-555000, 0.24428571) (-550000, 0.26542659) (-545455, 0.28536706) (-540455, 0.30410714) (-535455, 0.32164683) (-530455, 0.33798611) (-525455, 0.353125) (-520455, 0.36706349) (-515455, 0.37980159) (-510455, 0.39133929) (-505455, 0.40167659) (-500455, 0.41081349) (-495455, 0.41875) (-490455, 0.425625) (-485455, 0.4325) (-480455, 0.439375) (-475455, 0.44625) (-470455, 0.453125) (-465455, 0.46) (-460455, 0.466875) (-455455, 0.47375) (-450455, 0.480625) (-445455, 0.4875) (-440455, 0.494375) (-435455, 0.50125) (-430455, 0.508125) (-425455, 0.515) (-420455, 0.521875) (-415455, 0.52875) (-410455, 0.535625) (-405455, 0.5425)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} conductivity=625000 magnetic_coercivity{Magnitude=-599996.38A_per_meter DirComp1=1 DirComp2=0 DirComp3=0} lande_g_factor=2
  steel_stainless: conductivity=1100000

design ws7-1_BH (Maxwell 2D, Transient, XY geometry, model units mm)
notes: d axis elec phase: -195
d axis elec phase: 165
q axis elec phase: -105
q axis elec phase: 255
-d axis elec phase: -15
-d axis elec phase: 345
-q axis elec phase: 75
-q axis elec phase: 75
options: ComputeTransientInductance ModelDepth=65mm Notes="d axis elec phase: -195 / d axis elec phase: 165 / q axis elec phase: -105 / q axis elec phase: 255 / -d axis elec phase: -15 / -d axis elec phase: 345 / -q axis elec phase: 75 / -q axis elec phase: 75"
variables:
  fractions = 4
  f_e = w_f/(2*pi) Hz
  elec_phase = -105deg
  w_m = ((1500*2*pi)/60) rad_per_sec
  p = 2
  w_f = w_m*p rad_per_sec
  Ipk = 50A*sqrt(2)
  Ipk_a = 50A*sqrt(2)*pwl(ds1,time/1ms)
datasets:
  ds1: (0, 1) (2, 1) (2.75, 10) (4.5, 10) (5.25, 1) (32, 1)
geometry:
  Band [vacuum] = user_primitive(RMxprt/Band, DiaGap=74.5mm, DiaYoke=26mm, Length=0mm, SegAngle=1deg, Fractions=1, HalfAxial=0, InfoCore=0)
  Shaft [steel_stainless] = user_primitive(RMxprt/Band, DiaGap=74.5mm, DiaYoke=26mm, Length=0mm, SegAngle=1deg, Fractions=1, HalfAxial=0, InfoCore=100)
  OuterRegion [vacuum] = user_primitive(RMxprt/Band, DiaGap=74.5mm, DiaYoke=120mm, Length=0mm, SegAngle=1deg, Fractions=fractions, HalfAxial=0, InfoCore=100)
  Tool = user_primitive(RMxprt/Band, DiaGap=74.5mm, DiaYoke=120mm, Length=0mm, SegAngle=1deg, Fractions=fractions, HalfAxial=0, InfoCore=1)
  Stator [M19_24G_2DSF0.950] = user_primitive(RMxprt/SlotCore, DiaGap=75mm, DiaYoke=120mm, Length=0mm, Skew=0deg, Slots=24, SlotType=2, Hs0=0.5mm, Hs01=0mm, Hs1=1mm, Hs2=8.2mm, Bs0=2.5mm, Bs1=5.6mm, Bs2=7.6mm, Rs=3.8mm, FilletType=0, HalfSlot=0, SegAngle=15deg, LenRegion=0mm, InfoCore=0)
  Coil_0 [copper_75C] = user_primitive(RMxprt/LapCoil, DiaGap=75mm, DiaYoke=120mm, Length=0mm, Skew=0deg, Slots=24, SlotType=2, Hs0=0.5mm, Hs1=1mm, Hs2=8.2mm, Bs0=2.5mm, Bs1=5.6mm, Bs2=7.6mm, Rs=3.8mm, FilletType=0, Layers=2, CoilPitch=5, EndExt=0mm, SpanExt=0mm, BendAngle=0deg, SegAngle=10deg, LenRegion=0mm, InfoCoil=2)
  Coil_1..Coil_5 [copper_75C], Coil_6..Coil_23 = Coil_0.duplicate_around_axis(axis=Z, angle=15deg, total=24)
  Coil_0.unite(Coil_6, Coil_12, Coil_18)
  Coil_1.unite(Coil_7, Coil_13, Coil_19)
  Coil_2.unite(Coil_8, Coil_14, Coil_20)
  Coil_3.unite(Coil_9, Coil_15, Coil_21)
  Coil_4.unite(Coil_10, Coil_16, Coil_22)
  Coil_5.unite(Coil_11, Coil_17, Coil_23)
  CoilRe_0 [copper_75C] = user_primitive(RMxprt/LapCoil, DiaGap=75mm, DiaYoke=120mm, Length=0mm, Skew=0deg, Slots=24, SlotType=2, Hs0=0.5mm, Hs1=1mm, Hs2=8.2mm, Bs0=2.5mm, Bs1=5.6mm, Bs2=7.6mm, Rs=3.8mm, FilletType=0, Layers=2, CoilPitch=5, EndExt=0mm, SpanExt=0mm, BendAngle=0deg, SegAngle=10deg, LenRegion=0mm, InfoCoil=3)
  CoilRe_0.rotate(axis=Z, angle=-75deg)
  CoilRe_1..CoilRe_5 [copper_75C], CoilRe_6..CoilRe_23 = CoilRe_0.duplicate_around_axis(axis=Z, angle=15deg, total=24)
  CoilRe_0.unite(CoilRe_6, CoilRe_12, CoilRe_18)
  CoilRe_1.unite(CoilRe_7, CoilRe_13, CoilRe_19)
  CoilRe_2.unite(CoilRe_8, CoilRe_14, CoilRe_20)
  CoilRe_3.unite(CoilRe_9, CoilRe_15, CoilRe_21)
  CoilRe_4.unite(CoilRe_10, CoilRe_16, CoilRe_22)
  CoilRe_5.unite(CoilRe_11, CoilRe_17, CoilRe_23)
  Rotor [M19_24G_2DSF0.950] = user_primitive(RMxprt/IPMCore, DiaGap=74mm, DiaYoke=26mm, Length=0mm, Poles=4, PoleType=3, D1=72mm, O1=3mm, O2=3mm, B1=4mm, Rib=3mm, HRib=3mm, DminMag=0mm, ThickMag=5mm, WidthMag=40mm, LenRegion=0mm, InfoCore=0)
  Rotor.rotate(axis=Z, angle=45deg)
  Mag1_0 [XG196/96, oriented by ObjectCS1] = user_primitive(RMxprt/IPMCore, DiaGap=74mm, DiaYoke=26mm, Length=0mm, Poles=4, PoleType=3, D1=72mm, O1=3mm, O2=3mm, B1=4mm, Rib=3mm, HRib=3mm, DminMag=0mm, ThickMag=5mm, WidthMag=40mm, LenRegion=0mm, InfoCore=-1)
  Mag1_0.rotate(axis=Z, angle=45deg)
  Mag1_1, Mag1_2, Mag1_3 = Mag1_0.duplicate_around_axis(axis=Z, angle=90deg, total=4)
  Mag1_0.unite(Mag1_1, Mag1_2, Mag1_3)
  Mag2_0 [XG196/96, oriented by ObjectCS2] = user_primitive(RMxprt/IPMCore, DiaGap=74mm, DiaYoke=26mm, Length=0mm, Poles=4, PoleType=3, D1=72mm, O1=3mm, O2=3mm, B1=4mm, Rib=3mm, HRib=3mm, DminMag=0mm, ThickMag=5mm, WidthMag=40mm, LenRegion=0mm, InfoCore=-2)
  Mag2_0.rotate(axis=Z, angle=45deg)
  Mag2_1, Mag2_2, Mag2_3 = Mag2_0.duplicate_around_axis(axis=Z, angle=90deg, total=4)
  Mag2_0.unite(Mag2_1, Mag2_2, Mag2_3)
  InnerRegion [vacuum] = user_primitive(RMxprt/IPMCore, DiaGap=74mm, DiaYoke=26mm, Length=0mm, Poles=4, PoleType=3, D1=72mm, O1=3mm, O2=3mm, B1=4mm, Rib=3mm, HRib=3mm, DminMag=0mm, ThickMag=5mm, WidthMag=40mm, LenRegion=0mm, InfoCore=100)
  Tool_1 = Tool.copy()
  Band.subtract(Tool_1)
  Tool_2 = Tool.copy()
  InnerRegion.subtract(Tool_2)
  Tool_3 = Tool.copy()
  Shaft.subtract(Tool_3)
  Tool_4 = Tool.copy()
  Stator.subtract(Tool_4)
  Tool_5 = Tool.copy()
  Coil_0.subtract(Tool_5)
  Tool_6 = Tool.copy()
  Coil_1.subtract(Tool_6)
  Tool_7 = Tool.copy()
  Coil_2.subtract(Tool_7)
  Tool_8 = Tool.copy()
  Coil_3.subtract(Tool_8)
  Tool_9 = Tool.copy()
  Coil_4.subtract(Tool_9)
  Tool_10 = Tool.copy()
  Coil_5.subtract(Tool_10)
  Tool_11 = Tool.copy()
  CoilRe_0.subtract(Tool_11)
  Tool_12 = Tool.copy()
  CoilRe_1.subtract(Tool_12)
  Tool_13 = Tool.copy()
  CoilRe_2.subtract(Tool_13)
  Tool_14 = Tool.copy()
  CoilRe_3.subtract(Tool_14)
  Tool_15 = Tool.copy()
  CoilRe_4.subtract(Tool_15)
  Tool_16 = Tool.copy()
  CoilRe_5.subtract(Tool_16)
  Tool_17 = Tool.copy()
  Rotor.subtract(Tool_17)
  Tool_18 = Tool.copy()
  Mag1_0.subtract(Tool_18)
  Mag2_0.subtract(Tool)
  Circle1 [XG196/96, oriented by ObjectCS1] = circle(normal=Z, centre=(7.0684489mm, 23.621564mm, 0mm), radius=0.3mm)
  coordinate_system RelativeCS1 = origin=(0mm, 0mm, 0mm) x=(7.0684489mm, 23.621564mm, 0mm) y=(-23.621564mm, 7.0684489mm, 0mm)
  coordinate_system RelativeCS_5 = origin=(7.0684489mm, 23.621564mm, 0mm) x=(-3.8847125mm, 9.2146084mm, 0mm) y=(-9.2146084mm, -3.8847125mm, 0mm)
  coordinate_system ObjectCS1 = object of Mag1_0: Origin=Mag1_0.vertex(1 of 4) xAxisPos=Mag1_0.vertex(4 of 4) yAxis{xDirection=-0.38847125 yDirection=0.92146084 zDirection=0}
  coordinate_system ObjectCS2 = object of Mag2_0: Origin=Mag2_0.vertex(2 of 4) xAxisPos=Mag2_0.vertex(3 of 4) yAxis{xDirection=-0.92146084 yDirection=0.38847125 zDirection=0} in ObjectCS1
motion:
  MotionSetup1: Band Move_Type=Rotate Coordinate_System=Global Axis=Z Is_Positive=true InitPos=0deg Angular_Velocity=w_m Objects=Band
  Moving1: Moving Objects=[Shaft, Rotor, Mag1_0, Mag2_0, InnerRegion, Circle1]
boundaries and excitations:
  VectorPotential1: Vector Potential Edges=OuterRegion.edge(at (42.4264, 42.4264, 0)) Value=0
  Master1: Master Edges=OuterRegion.edge(at (30, 0, 0))
  Slave1: Slave Edges=OuterRegion.edge(at (0, 30, 0)) ReverseU master=Master1 SameAsMaster=false
  PhA_0: Coil Objects=Coil_0 Conductor_number=26 Winding=PhaseA PolarityType=Positive
  PhARe_0: Coil Objects=CoilRe_5 Conductor_number=26 Winding=PhaseA PolarityType=Negative
  PhA_1: Coil Objects=Coil_1 Conductor_number=26 Winding=PhaseA PolarityType=Positive
  PhCRe_2: Coil Objects=Coil_2 Conductor_number=26 Winding=PhaseC PolarityType=Negative
  PhCRe_3: Coil Objects=Coil_3 Conductor_number=26 Winding=PhaseC PolarityType=Negative
  PhB_4: Coil Objects=Coil_4 Conductor_number=26 Winding=PhaseB PolarityType=Positive
  PhB_5: Coil Objects=Coil_5 Conductor_number=26 Winding=PhaseB PolarityType=Positive
  PhA_19: Coil Objects=CoilRe_0 Conductor_number=26 Winding=PhaseA PolarityType=Positive
  PhCRe_20: Coil Objects=CoilRe_1 Conductor_number=26 Winding=PhaseC PolarityType=Negative
  PhCRe_21: Coil Objects=CoilRe_2 Conductor_number=26 Winding=PhaseC PolarityType=Negative
  PhB_22: Coil Objects=CoilRe_3 Conductor_number=26 Winding=PhaseB PolarityType=Positive
  PhB_23: Coil Objects=CoilRe_4 Conductor_number=26 Winding=PhaseB PolarityType=Positive
  PhaseA: Winding Group Type=Current IsSolid=false Current=Ipk_a*cos(2*pi*f_e*time+elec_phase) ParallelBranchesNum=1
  PhaseB: Winding Group Type=Current IsSolid=false Current=Ipk*cos(2*pi*f_e*time+elec_phase-120deg) ParallelBranchesNum=1
  PhaseC: Winding Group Type=Current IsSolid=false Current=Ipk*cos(2*pi*f_e*time+elec_phase-240deg) ParallelBranchesNum=1
mesh:
  Length_Coil: LengthBased RefineInside Objects=[Coil_0..Coil_5, CoilRe_0..CoilRe_5] MaxLength=3mm
  Length_Mag: LengthBased RefineInside Objects=[Mag1_0, Mag2_0] MaxLength=3mm
  SurfApprox_Mag: SurfApproxBased Objects=[Mag1_0, Mag2_0] CurvedSurfaceApproxChoice=ManualSettings SurfDev=0.037mm NormalDev=15deg
  SurfApprox_Main: SurfApproxBased Objects=[Stator, Rotor, Band, OuterRegion, InnerRegion, Shaft] CurvedSurfaceApproxChoice=ManualSettings SurfDev=0.06mm NormalDev=15deg
  Length_Main: LengthBased RefineInside Objects=[Stator, Rotor, Band, OuterRegion, InnerRegion, Shaft] MaxLength=3mm
  Length1: LengthBased Edges=Rotor.edge(3 of 74, 4 of 74, 5 of 74, 6 of 74, 7 of 74, 8 of 74, 9 of 74, 10 of 74, 11 of 74, 12 of 74, 13 of 74, 14 of 74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) MaxLength=0.75mm
  initial mesh: MeshMethod=AnsoftTAU
setups:
  Setup1: Transient NonlinearSolverResidual=1e-05 StopTime=4/(2.5*f_e) TimeStep=1/f_e/200 SaveFieldsType=Custom SweepRanges{0ms to 32000000ns step 100000ns} NumberSolveSteps=1 RangeStart=0s RangeEnd=0.1s InitialTimeStep=0.002s MinTimeStep=0.001s MaxTimeStep=0.003s TimeStepErrTolerance=0.0001
output variables:
  pos = Moving1.Position * 2 - 13*PI/12
  cos0 = cos(pos)
  cos1 = cos(pos-2*PI/3)
  cos2 = cos(pos-4*PI/3)
  sin0 = sin(pos)
  sin1 = sin(pos-2*PI/3)
  sin2 = sin(pos-4*PI/3)
  Lad = L(PhaseA,PhaseA)*cos0 + L(PhaseA,PhaseB)*cos1 + L(PhaseA,PhaseC)*cos2
  Laq = L(PhaseA,PhaseA)*sin0 + L(PhaseA,PhaseB)*sin1 + L(PhaseA,PhaseC)*sin2
  Lbd = L(PhaseB,PhaseA)*cos0 + L(PhaseB,PhaseB)*cos1 + L(PhaseB,PhaseC)*cos2
  Lbq = L(PhaseB,PhaseA)*sin0 + L(PhaseB,PhaseB)*sin1 + L(PhaseB,PhaseC)*sin2
  Lcd = L(PhaseC,PhaseA)*cos0 + L(PhaseC,PhaseB)*cos1 + L(PhaseC,PhaseC)*cos2
  Lcq = L(PhaseC,PhaseA)*sin0 + L(PhaseC,PhaseB)*sin1 + L(PhaseC,PhaseC)*sin2
  L_d = (Lad*cos0 + Lbd*cos1 + Lcd*cos2) * 2/3
  L_q = (Laq*sin0 + Lbq*sin1 + Lcq*sin2) * 2/3
  Flux_d = FluxLinkage(PhaseA)*cos0 + FluxLinkage(PhaseB)*cos1 + FluxLinkage(PhaseC)*cos2
  Flux_q = FluxLinkage(PhaseA)*sin0 + FluxLinkage(PhaseB)*sin1 + FluxLinkage(PhaseC)*sin2
  I_d = InputCurrent(PhaseA)*cos0 + InputCurrent(PhaseB)*cos1 + InputCurrent(PhaseC)*cos2
  I_q = InputCurrent(PhaseA)*-sin0 + InputCurrent(PhaseB)*-sin1 + InputCurrent(PhaseC)*-sin2
field calculator expressions:
  Detection_circle_area = 1 | EnterSurface(Circle1) | SurfaceValue | Integrate
  B_1 = Fundamental_Quantity(22) | EnterCoord(ObjectCS1) | UnitVecCSX | Dot | EnterSurface(Circle1) | SurfaceValue | Integrate | Detection_circle_area | /
  H_1 = Fundamental_Quantity(21) | EnterCoord(ObjectCS1) | UnitVecCSX | Dot | EnterSurface(Circle1) | SurfaceValue | Integrate | Detection_circle_area | /
field plots:
  Mesh1: MeshPlots over a plane on Setup1 : Transient at Time=-1
  B_Vector1: B1 over Mag1_0 on Setup1 : Transient at Time=-1
  Mag_B1: B over Mag1_0, Circle1 on Setup1 : Transient at Time=-1
  Jz1: J over Coil_0..Coil_5, CoilRe_0..CoilRe_5 on Setup1 : Transient at Time=-1
  Flux_Lines1: A over Band, Shaft, OuterRegion, Stator, Coil_0..Coil_5, CoilRe_0..CoilRe_5, Rotor, Mag1_0, Mag2_0, InnerRegion, Circle1 on Setup1 : Transient at Time=-1
reports:
  Stator Currents: InputCurrent(PhaseA), InputCurrent(PhaseB), InputCurrent(PhaseC) vs Time on Setup1 : Transient; markers m1 at 3.8888968ms
  Moving Torque: Moving1.Torque vs Time on Setup1 : Transient [elec_phase=all]
  L_dq: L_d, L_q vs Time on Setup1 : Transient
  Flux_dq: Flux_d, Flux_q vs Time on Setup1 : Transient
  I_dq: I_d, I_q vs Time on Setup1 : Transient
  Recoil_curve: Y Component 1 vs Primary Sweep; B_1 vs H_1 on Setup1 : Transient [Time=all]

design VAC633AP20degC (Maxwell 2D, Transient, XY geometry, model units mm)
notes: d axis elec phase: -195
d axis elec phase: 165
q axis elec phase: -105
q axis elec phase: 255
-d axis elec phase: -15
-d axis elec phase: 345
-q axis elec phase: 75
-q axis elec phase: 75
options: ComputeTransientInductance ModelDepth=65mm Notes="d axis elec phase: -195 / d axis elec phase: 165 / q axis elec phase: -105 / q axis elec phase: 255 / -d axis elec phase: -15 / -d axis elec phase: 345 / -q axis elec phase: 75 / -q axis elec phase: 75"
variables:
  fractions = 4
  f_e = w_f/(2*pi) Hz
  elec_phase = -105deg
  w_m = ((1500*2*pi)/60) rad_per_sec
  p = 2
  w_f = w_m*p rad_per_sec
  Ipk = 50A*sqrt(2)
  Ipk_a = 50A*sqrt(2)*pwl(ds1,time/1ms)
datasets:
  ds1: (0, 1) (2, 1) (2.75, 10) (4.5, 10) (5.25, 1) (32, 1)
geometry:
  Band [vacuum] = user_primitive(RMxprt/Band, DiaGap=74.5mm, DiaYoke=26mm, Length=0mm, SegAngle=1deg, Fractions=1, HalfAxial=0, InfoCore=0)
  Shaft [steel_stainless] = user_primitive(RMxprt/Band, DiaGap=74.5mm, DiaYoke=26mm, Length=0mm, SegAngle=1deg, Fractions=1, HalfAxial=0, InfoCore=100)
  OuterRegion [vacuum] = user_primitive(RMxprt/Band, DiaGap=74.5mm, DiaYoke=120mm, Length=0mm, SegAngle=1deg, Fractions=fractions, HalfAxial=0, InfoCore=100)
  Tool = user_primitive(RMxprt/Band, DiaGap=74.5mm, DiaYoke=120mm, Length=0mm, SegAngle=1deg, Fractions=fractions, HalfAxial=0, InfoCore=1)
  Stator [M19_24G_2DSF0.950] = user_primitive(RMxprt/SlotCore, DiaGap=75mm, DiaYoke=120mm, Length=0mm, Skew=0deg, Slots=24, SlotType=2, Hs0=0.5mm, Hs01=0mm, Hs1=1mm, Hs2=8.2mm, Bs0=2.5mm, Bs1=5.6mm, Bs2=7.6mm, Rs=3.8mm, FilletType=0, HalfSlot=0, SegAngle=15deg, LenRegion=0mm, InfoCore=0)
  Coil_0 [copper_75C] = user_primitive(RMxprt/LapCoil, DiaGap=75mm, DiaYoke=120mm, Length=0mm, Skew=0deg, Slots=24, SlotType=2, Hs0=0.5mm, Hs1=1mm, Hs2=8.2mm, Bs0=2.5mm, Bs1=5.6mm, Bs2=7.6mm, Rs=3.8mm, FilletType=0, Layers=2, CoilPitch=5, EndExt=0mm, SpanExt=0mm, BendAngle=0deg, SegAngle=10deg, LenRegion=0mm, InfoCoil=2)
  Coil_1..Coil_5 [copper_75C], Coil_6..Coil_23 = Coil_0.duplicate_around_axis(axis=Z, angle=15deg, total=24)
  Coil_0.unite(Coil_6, Coil_12, Coil_18)
  Coil_1.unite(Coil_7, Coil_13, Coil_19)
  Coil_2.unite(Coil_8, Coil_14, Coil_20)
  Coil_3.unite(Coil_9, Coil_15, Coil_21)
  Coil_4.unite(Coil_10, Coil_16, Coil_22)
  Coil_5.unite(Coil_11, Coil_17, Coil_23)
  CoilRe_0 [copper_75C] = user_primitive(RMxprt/LapCoil, DiaGap=75mm, DiaYoke=120mm, Length=0mm, Skew=0deg, Slots=24, SlotType=2, Hs0=0.5mm, Hs1=1mm, Hs2=8.2mm, Bs0=2.5mm, Bs1=5.6mm, Bs2=7.6mm, Rs=3.8mm, FilletType=0, Layers=2, CoilPitch=5, EndExt=0mm, SpanExt=0mm, BendAngle=0deg, SegAngle=10deg, LenRegion=0mm, InfoCoil=3)
  CoilRe_0.rotate(axis=Z, angle=-75deg)
  CoilRe_1..CoilRe_5 [copper_75C], CoilRe_6..CoilRe_23 = CoilRe_0.duplicate_around_axis(axis=Z, angle=15deg, total=24)
  CoilRe_0.unite(CoilRe_6, CoilRe_12, CoilRe_18)
  CoilRe_1.unite(CoilRe_7, CoilRe_13, CoilRe_19)
  CoilRe_2.unite(CoilRe_8, CoilRe_14, CoilRe_20)
  CoilRe_3.unite(CoilRe_9, CoilRe_15, CoilRe_21)
  CoilRe_4.unite(CoilRe_10, CoilRe_16, CoilRe_22)
  CoilRe_5.unite(CoilRe_11, CoilRe_17, CoilRe_23)
  Rotor [M19_24G_2DSF0.950] = user_primitive(RMxprt/IPMCore, DiaGap=74mm, DiaYoke=26mm, Length=0mm, Poles=4, PoleType=3, D1=72mm, O1=3mm, O2=3mm, B1=4mm, Rib=3mm, HRib=3mm, DminMag=0mm, ThickMag=5mm, WidthMag=40mm, LenRegion=0mm, InfoCore=0)
  Rotor.rotate(axis=Z, angle=45deg)
  Mag1_0 [VACODYM 633AP  20Â°C, oriented by ObjectCS1] = user_primitive(RMxprt/IPMCore, DiaGap=74mm, DiaYoke=26mm, Length=0mm, Poles=4, PoleType=3, D1=72mm, O1=3mm, O2=3mm, B1=4mm, Rib=3mm, HRib=3mm, DminMag=0mm, ThickMag=5mm, WidthMag=40mm, LenRegion=0mm, InfoCore=-1)
  Mag1_0.rotate(axis=Z, angle=45deg)
  Mag1_1, Mag1_2, Mag1_3 = Mag1_0.duplicate_around_axis(axis=Z, angle=90deg, total=4)
  Mag1_0.unite(Mag1_1, Mag1_2, Mag1_3)
  Mag2_0 [VACODYM 633AP  20Â°C, oriented by ObjectCS2] = user_primitive(RMxprt/IPMCore, DiaGap=74mm, DiaYoke=26mm, Length=0mm, Poles=4, PoleType=3, D1=72mm, O1=3mm, O2=3mm, B1=4mm, Rib=3mm, HRib=3mm, DminMag=0mm, ThickMag=5mm, WidthMag=40mm, LenRegion=0mm, InfoCore=-2)
  Mag2_0.rotate(axis=Z, angle=45deg)
  Mag2_1, Mag2_2, Mag2_3 = Mag2_0.duplicate_around_axis(axis=Z, angle=90deg, total=4)
  Mag2_0.unite(Mag2_1, Mag2_2, Mag2_3)
  InnerRegion [vacuum] = user_primitive(RMxprt/IPMCore, DiaGap=74mm, DiaYoke=26mm, Length=0mm, Poles=4, PoleType=3, D1=72mm, O1=3mm, O2=3mm, B1=4mm, Rib=3mm, HRib=3mm, DminMag=0mm, ThickMag=5mm, WidthMag=40mm, LenRegion=0mm, InfoCore=100)
  Tool_1 = Tool.copy()
  Band.subtract(Tool_1)
  Tool_2 = Tool.copy()
  InnerRegion.subtract(Tool_2)
  Tool_3 = Tool.copy()
  Shaft.subtract(Tool_3)
  Tool_4 = Tool.copy()
  Stator.subtract(Tool_4)
  Tool_5 = Tool.copy()
  Coil_0.subtract(Tool_5)
  Tool_6 = Tool.copy()
  Coil_1.subtract(Tool_6)
  Tool_7 = Tool.copy()
  Coil_2.subtract(Tool_7)
  Tool_8 = Tool.copy()
  Coil_3.subtract(Tool_8)
  Tool_9 = Tool.copy()
  Coil_4.subtract(Tool_9)
  Tool_10 = Tool.copy()
  Coil_5.subtract(Tool_10)
  Tool_11 = Tool.copy()
  CoilRe_0.subtract(Tool_11)
  Tool_12 = Tool.copy()
  CoilRe_1.subtract(Tool_12)
  Tool_13 = Tool.copy()
  CoilRe_2.subtract(Tool_13)
  Tool_14 = Tool.copy()
  CoilRe_3.subtract(Tool_14)
  Tool_15 = Tool.copy()
  CoilRe_4.subtract(Tool_15)
  Tool_16 = Tool.copy()
  CoilRe_5.subtract(Tool_16)
  Tool_17 = Tool.copy()
  Rotor.subtract(Tool_17)
  Tool_18 = Tool.copy()
  Mag1_0.subtract(Tool_18)
  Mag2_0.subtract(Tool)
  Circle1 [VACODYM 633AP  20Â°C, oriented by ObjectCS1] = circle(normal=Z, centre=(7.0684489mm, 23.621564mm, 0mm), radius=0.3mm)
  coordinate_system RelativeCS1 = origin=(0mm, 0mm, 0mm) x=(7.0684489mm, 23.621564mm, 0mm) y=(-23.621564mm, 7.0684489mm, 0mm)
  coordinate_system RelativeCS_5 = origin=(7.0684489mm, 23.621564mm, 0mm) x=(-3.8847125mm, 9.2146084mm, 0mm) y=(-9.2146084mm, -3.8847125mm, 0mm)
  coordinate_system ObjectCS1 = object of Mag1_0: Origin=Mag1_0.vertex(1 of 4) xAxisPos=Mag1_0.vertex(4 of 4) yAxis{xDirection=-0.38847125 yDirection=0.92146084 zDirection=0}
  coordinate_system ObjectCS2 = object of Mag2_0: Origin=Mag2_0.vertex(2 of 4) xAxisPos=Mag2_0.vertex(3 of 4) yAxis{xDirection=-0.92146084 yDirection=0.38847125 zDirection=0} in ObjectCS1
motion:
  MotionSetup1: Band Move_Type=Rotate Coordinate_System=Global Axis=Z Is_Positive=true InitPos=0deg Angular_Velocity=w_m Objects=Band
  Moving1: Moving Objects=[Shaft, Rotor, Mag1_0, Mag2_0, InnerRegion, Circle1]
boundaries and excitations:
  VectorPotential1: Vector Potential Edges=OuterRegion.edge(at (42.4264, 42.4264, 0)) Value=0
  Master1: Master Edges=OuterRegion.edge(at (30, 0, 0))
  Slave1: Slave Edges=OuterRegion.edge(at (0, 30, 0)) ReverseU master=Master1 SameAsMaster=false
  PhA_0: Coil Objects=Coil_0 Conductor_number=26 Winding=PhaseA PolarityType=Positive
  PhARe_0: Coil Objects=CoilRe_5 Conductor_number=26 Winding=PhaseA PolarityType=Negative
  PhA_1: Coil Objects=Coil_1 Conductor_number=26 Winding=PhaseA PolarityType=Positive
  PhCRe_2: Coil Objects=Coil_2 Conductor_number=26 Winding=PhaseC PolarityType=Negative
  PhCRe_3: Coil Objects=Coil_3 Conductor_number=26 Winding=PhaseC PolarityType=Negative
  PhB_4: Coil Objects=Coil_4 Conductor_number=26 Winding=PhaseB PolarityType=Positive
  PhB_5: Coil Objects=Coil_5 Conductor_number=26 Winding=PhaseB PolarityType=Positive
  PhA_19: Coil Objects=CoilRe_0 Conductor_number=26 Winding=PhaseA PolarityType=Positive
  PhCRe_20: Coil Objects=CoilRe_1 Conductor_number=26 Winding=PhaseC PolarityType=Negative
  PhCRe_21: Coil Objects=CoilRe_2 Conductor_number=26 Winding=PhaseC PolarityType=Negative
  PhB_22: Coil Objects=CoilRe_3 Conductor_number=26 Winding=PhaseB PolarityType=Positive
  PhB_23: Coil Objects=CoilRe_4 Conductor_number=26 Winding=PhaseB PolarityType=Positive
  PhaseA: Winding Group Type=Current IsSolid=false Current=Ipk_a*cos(2*pi*f_e*time+elec_phase) ParallelBranchesNum=1
  PhaseB: Winding Group Type=Current IsSolid=false Current=Ipk*cos(2*pi*f_e*time+elec_phase-120deg) ParallelBranchesNum=1
  PhaseC: Winding Group Type=Current IsSolid=false Current=Ipk*cos(2*pi*f_e*time+elec_phase-240deg) ParallelBranchesNum=1
mesh:
  Length_Coil: LengthBased RefineInside Objects=[Coil_0..Coil_5, CoilRe_0..CoilRe_5] MaxLength=3mm
  Length_Mag: LengthBased RefineInside Objects=[Mag1_0, Mag2_0] MaxLength=3mm
  SurfApprox_Mag: SurfApproxBased Objects=[Mag1_0, Mag2_0] CurvedSurfaceApproxChoice=ManualSettings SurfDev=0.037mm NormalDev=15deg
  SurfApprox_Main: SurfApproxBased Objects=[Stator, Rotor, Band, OuterRegion, InnerRegion, Shaft] CurvedSurfaceApproxChoice=ManualSettings SurfDev=0.06mm NormalDev=15deg
  Length_Main: LengthBased RefineInside Objects=[Stator, Rotor, Band, OuterRegion, InnerRegion, Shaft] MaxLength=3mm
  Length1: LengthBased Edges=Rotor.edge(3 of 74, 4 of 74, 5 of 74, 6 of 74, 7 of 74, 8 of 74, 9 of 74, 10 of 74, 11 of 74, 12 of 74, 13 of 74, 14 of 74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) MaxLength=0.75mm
  initial mesh: MeshMethod=AnsoftTAU
setups:
  Setup1: Transient NonlinearSolverResidual=1e-05 StopTime=4/(2.5*f_e) TimeStep=1/f_e/200 SaveFieldsType=Custom SweepRanges{0ms to 32000000ns step 100000ns} NumberSolveSteps=1 RangeStart=0s RangeEnd=0.1s InitialTimeStep=0.002s MinTimeStep=0.001s MaxTimeStep=0.003s TimeStepErrTolerance=0.0001
output variables:
  pos = Moving1.Position * 2 - 13*PI/12
  cos0 = cos(pos)
  cos1 = cos(pos-2*PI/3)
  cos2 = cos(pos-4*PI/3)
  sin0 = sin(pos)
  sin1 = sin(pos-2*PI/3)
  sin2 = sin(pos-4*PI/3)
  Lad = L(PhaseA,PhaseA)*cos0 + L(PhaseA,PhaseB)*cos1 + L(PhaseA,PhaseC)*cos2
  Laq = L(PhaseA,PhaseA)*sin0 + L(PhaseA,PhaseB)*sin1 + L(PhaseA,PhaseC)*sin2
  Lbd = L(PhaseB,PhaseA)*cos0 + L(PhaseB,PhaseB)*cos1 + L(PhaseB,PhaseC)*cos2
  Lbq = L(PhaseB,PhaseA)*sin0 + L(PhaseB,PhaseB)*sin1 + L(PhaseB,PhaseC)*sin2
  Lcd = L(PhaseC,PhaseA)*cos0 + L(PhaseC,PhaseB)*cos1 + L(PhaseC,PhaseC)*cos2
  Lcq = L(PhaseC,PhaseA)*sin0 + L(PhaseC,PhaseB)*sin1 + L(PhaseC,PhaseC)*sin2
  L_d = (Lad*cos0 + Lbd*cos1 + Lcd*cos2) * 2/3
  L_q = (Laq*sin0 + Lbq*sin1 + Lcq*sin2) * 2/3
  Flux_d = FluxLinkage(PhaseA)*cos0 + FluxLinkage(PhaseB)*cos1 + FluxLinkage(PhaseC)*cos2
  Flux_q = FluxLinkage(PhaseA)*sin0 + FluxLinkage(PhaseB)*sin1 + FluxLinkage(PhaseC)*sin2
  I_d = InputCurrent(PhaseA)*cos0 + InputCurrent(PhaseB)*cos1 + InputCurrent(PhaseC)*cos2
  I_q = InputCurrent(PhaseA)*-sin0 + InputCurrent(PhaseB)*-sin1 + InputCurrent(PhaseC)*-sin2
field calculator expressions:
  Detection_circle_area = 1 | EnterSurface(Circle1) | SurfaceValue | Integrate
  B_1 = Fundamental_Quantity(22) | EnterCoord(ObjectCS1) | UnitVecCSX | Dot | EnterSurface(Circle1) | SurfaceValue | Integrate | Detection_circle_area | /
  H_1 = Fundamental_Quantity(21) | EnterCoord(ObjectCS1) | UnitVecCSX | Dot | EnterSurface(Circle1) | SurfaceValue | Integrate | Detection_circle_area | /
field plots:
  Mesh1: MeshPlots over a plane on Setup1 : Transient at Time=-1
  B_Vector1: B1 over Mag1_0 on Setup1 : Transient at Time=-1
  Mag_B1: B over Mag1_0, Circle1 on Setup1 : Transient at Time=-1
  Jz1: J over Coil_0..Coil_5, CoilRe_0..CoilRe_5 on Setup1 : Transient at Time=-1
  Flux_Lines1: A over Band, Shaft, OuterRegion, Stator, Coil_0..Coil_5, CoilRe_0..CoilRe_5, Rotor, Mag1_0, Mag2_0, InnerRegion, Circle1 on Setup1 : Transient at Time=-1
reports:
  Stator Currents: InputCurrent(PhaseA), InputCurrent(PhaseB), InputCurrent(PhaseC) vs Time on Setup1 : Transient; markers m1 at 3.8888968ms
  Moving Torque: Moving1.Torque vs Time on Setup1 : Transient [elec_phase=all]
  L_dq: L_d, L_q vs Time on Setup1 : Transient
  Flux_dq: Flux_d, Flux_q vs Time on Setup1 : Transient
  I_dq: I_d, I_q vs Time on Setup1 : Transient
  Recoil_curve: B(tesla) vs H(A/m); B_1 vs H_1 on Setup1 : Transient [Time=all]

design EE361-MT1-Q1-BH180degC (Maxwell 2D, Transient, XY geometry, model units mm)
notes: d axis elec phase: -195
d axis elec phase: 165
q axis elec phase: -105
q axis elec phase: 255
-d axis elec phase: -15
-d axis elec phase: 345
-q axis elec phase: 75
-q axis elec phase: 75
options: ComputeTransientInductance ModelDepth=65mm Notes="d axis elec phase: -195 / d axis elec phase: 165 / q axis elec phase: -105 / q axis elec phase: 255 / -d axis elec phase: -15 / -d axis elec phase: 345 / -q axis elec phase: 75 / -q axis elec phase: 75"
variables:
  fractions = 4
  f_e = w_f/(2*pi) Hz
  elec_phase = -105deg
  w_m = ((1500*2*pi)/60) rad_per_sec
  p = 2
  w_f = w_m*p rad_per_sec
  Ipk = 50A*sqrt(2)
  Ipk_a = 50A*sqrt(2)*pwl(ds1,time/1ms)
datasets:
  ds1: (0, 1) (2, 1) (2.75, 10) (4.5, 10) (5.25, 1) (32, 1)
geometry:
  Band [vacuum] = user_primitive(RMxprt/Band, DiaGap=74.5mm, DiaYoke=26mm, Length=0mm, SegAngle=1deg, Fractions=1, HalfAxial=0, InfoCore=0)
  Shaft [steel_stainless] = user_primitive(RMxprt/Band, DiaGap=74.5mm, DiaYoke=26mm, Length=0mm, SegAngle=1deg, Fractions=1, HalfAxial=0, InfoCore=100)
  OuterRegion [vacuum] = user_primitive(RMxprt/Band, DiaGap=74.5mm, DiaYoke=120mm, Length=0mm, SegAngle=1deg, Fractions=fractions, HalfAxial=0, InfoCore=100)
  Tool = user_primitive(RMxprt/Band, DiaGap=74.5mm, DiaYoke=120mm, Length=0mm, SegAngle=1deg, Fractions=fractions, HalfAxial=0, InfoCore=1)
  Stator [M19_24G_2DSF0.950] = user_primitive(RMxprt/SlotCore, DiaGap=75mm, DiaYoke=120mm, Length=0mm, Skew=0deg, Slots=24, SlotType=2, Hs0=0.5mm, Hs01=0mm, Hs1=1mm, Hs2=8.2mm, Bs0=2.5mm, Bs1=5.6mm, Bs2=7.6mm, Rs=3.8mm, FilletType=0, HalfSlot=0, SegAngle=15deg, LenRegion=0mm, InfoCore=0)
  Coil_0 [copper_75C] = user_primitive(RMxprt/LapCoil, DiaGap=75mm, DiaYoke=120mm, Length=0mm, Skew=0deg, Slots=24, SlotType=2, Hs0=0.5mm, Hs1=1mm, Hs2=8.2mm, Bs0=2.5mm, Bs1=5.6mm, Bs2=7.6mm, Rs=3.8mm, FilletType=0, Layers=2, CoilPitch=5, EndExt=0mm, SpanExt=0mm, BendAngle=0deg, SegAngle=10deg, LenRegion=0mm, InfoCoil=2)
  Coil_1..Coil_5 [copper_75C], Coil_6..Coil_23 = Coil_0.duplicate_around_axis(axis=Z, angle=15deg, total=24)
  Coil_0.unite(Coil_6, Coil_12, Coil_18)
  Coil_1.unite(Coil_7, Coil_13, Coil_19)
  Coil_2.unite(Coil_8, Coil_14, Coil_20)
  Coil_3.unite(Coil_9, Coil_15, Coil_21)
  Coil_4.unite(Coil_10, Coil_16, Coil_22)
  Coil_5.unite(Coil_11, Coil_17, Coil_23)
  CoilRe_0 [copper_75C] = user_primitive(RMxprt/LapCoil, DiaGap=75mm, DiaYoke=120mm, Length=0mm, Skew=0deg, Slots=24, SlotType=2, Hs0=0.5mm, Hs1=1mm, Hs2=8.2mm, Bs0=2.5mm, Bs1=5.6mm, Bs2=7.6mm, Rs=3.8mm, FilletType=0, Layers=2, CoilPitch=5, EndExt=0mm, SpanExt=0mm, BendAngle=0deg, SegAngle=10deg, LenRegion=0mm, InfoCoil=3)
  CoilRe_0.rotate(axis=Z, angle=-75deg)
  CoilRe_1..CoilRe_5 [copper_75C], CoilRe_6..CoilRe_23 = CoilRe_0.duplicate_around_axis(axis=Z, angle=15deg, total=24)
  CoilRe_0.unite(CoilRe_6, CoilRe_12, CoilRe_18)
  CoilRe_1.unite(CoilRe_7, CoilRe_13, CoilRe_19)
  CoilRe_2.unite(CoilRe_8, CoilRe_14, CoilRe_20)
  CoilRe_3.unite(CoilRe_9, CoilRe_15, CoilRe_21)
  CoilRe_4.unite(CoilRe_10, CoilRe_16, CoilRe_22)
  CoilRe_5.unite(CoilRe_11, CoilRe_17, CoilRe_23)
  Rotor [M19_24G_2DSF0.950] = user_primitive(RMxprt/IPMCore, DiaGap=74mm, DiaYoke=26mm, Length=0mm, Poles=4, PoleType=3, D1=72mm, O1=3mm, O2=3mm, B1=4mm, Rib=3mm, HRib=3mm, DminMag=0mm, ThickMag=5mm, WidthMag=40mm, LenRegion=0mm, InfoCore=0)
  Rotor.rotate(axis=Z, angle=45deg)
  Mag1_0 [NdFe35, oriented by ObjectCS1] = user_primitive(RMxprt/IPMCore, DiaGap=74mm, DiaYoke=26mm, Length=0mm, Poles=4, PoleType=3, D1=72mm, O1=3mm, O2=3mm, B1=4mm, Rib=3mm, HRib=3mm, DminMag=0mm, ThickMag=5mm, WidthMag=40mm, LenRegion=0mm, InfoCore=-1)
  Mag1_0.rotate(axis=Z, angle=45deg)
  Mag1_1, Mag1_2, Mag1_3 = Mag1_0.duplicate_around_axis(axis=Z, angle=90deg, total=4)
  Mag1_0.unite(Mag1_1, Mag1_2, Mag1_3)
  Mag2_0 [NdFe35, oriented by ObjectCS2] = user_primitive(RMxprt/IPMCore, DiaGap=74mm, DiaYoke=26mm, Length=0mm, Poles=4, PoleType=3, D1=72mm, O1=3mm, O2=3mm, B1=4mm, Rib=3mm, HRib=3mm, DminMag=0mm, ThickMag=5mm, WidthMag=40mm, LenRegion=0mm, InfoCore=-2)
  Mag2_0.rotate(axis=Z, angle=45deg)
  Mag2_1, Mag2_2, Mag2_3 = Mag2_0.duplicate_around_axis(axis=Z, angle=90deg, total=4)
  Mag2_0.unite(Mag2_1, Mag2_2, Mag2_3)
  InnerRegion [vacuum] = user_primitive(RMxprt/IPMCore, DiaGap=74mm, DiaYoke=26mm, Length=0mm, Poles=4, PoleType=3, D1=72mm, O1=3mm, O2=3mm, B1=4mm, Rib=3mm, HRib=3mm, DminMag=0mm, ThickMag=5mm, WidthMag=40mm, LenRegion=0mm, InfoCore=100)
  Tool_1 = Tool.copy()
  Band.subtract(Tool_1)
  Tool_2 = Tool.copy()
  InnerRegion.subtract(Tool_2)
  Tool_3 = Tool.copy()
  Shaft.subtract(Tool_3)
  Tool_4 = Tool.copy()
  Stator.subtract(Tool_4)
  Tool_5 = Tool.copy()
  Coil_0.subtract(Tool_5)
  Tool_6 = Tool.copy()
  Coil_1.subtract(Tool_6)
  Tool_7 = Tool.copy()
  Coil_2.subtract(Tool_7)
  Tool_8 = Tool.copy()
  Coil_3.subtract(Tool_8)
  Tool_9 = Tool.copy()
  Coil_4.subtract(Tool_9)
  Tool_10 = Tool.copy()
  Coil_5.subtract(Tool_10)
  Tool_11 = Tool.copy()
  CoilRe_0.subtract(Tool_11)
  Tool_12 = Tool.copy()
  CoilRe_1.subtract(Tool_12)
  Tool_13 = Tool.copy()
  CoilRe_2.subtract(Tool_13)
  Tool_14 = Tool.copy()
  CoilRe_3.subtract(Tool_14)
  Tool_15 = Tool.copy()
  CoilRe_4.subtract(Tool_15)
  Tool_16 = Tool.copy()
  CoilRe_5.subtract(Tool_16)
  Tool_17 = Tool.copy()
  Rotor.subtract(Tool_17)
  Tool_18 = Tool.copy()
  Mag1_0.subtract(Tool_18)
  Mag2_0.subtract(Tool)
  Circle1 [NdFe35, oriented by ObjectCS1] = circle(normal=Z, centre=(7.0684489mm, 23.621564mm, 0mm), radius=0.3mm)
  coordinate_system RelativeCS1 = origin=(0mm, 0mm, 0mm) x=(7.0684489mm, 23.621564mm, 0mm) y=(-23.621564mm, 7.0684489mm, 0mm)
  coordinate_system RelativeCS_5 = origin=(7.0684489mm, 23.621564mm, 0mm) x=(-3.8847125mm, 9.2146084mm, 0mm) y=(-9.2146084mm, -3.8847125mm, 0mm)
  coordinate_system ObjectCS1 = object of Mag1_0: Origin=Mag1_0.vertex(1 of 4) xAxisPos=Mag1_0.vertex(4 of 4) yAxis{xDirection=-0.38847125 yDirection=0.92146084 zDirection=0}
  coordinate_system ObjectCS2 = object of Mag2_0: Origin=Mag2_0.vertex(2 of 4) xAxisPos=Mag2_0.vertex(3 of 4) yAxis{xDirection=-0.92146084 yDirection=0.38847125 zDirection=0} in ObjectCS1
motion:
  MotionSetup1: Band Move_Type=Rotate Coordinate_System=Global Axis=Z Is_Positive=true InitPos=0deg Angular_Velocity=w_m Objects=Band
  Moving1: Moving Objects=[Shaft, Rotor, Mag1_0, Mag2_0, InnerRegion, Circle1]
boundaries and excitations:
  VectorPotential1: Vector Potential Edges=OuterRegion.edge(at (42.4264, 42.4264, 0)) Value=0
  Master1: Master Edges=OuterRegion.edge(at (30, 0, 0))
  Slave1: Slave Edges=OuterRegion.edge(at (0, 30, 0)) ReverseU master=Master1 SameAsMaster=false
  PhA_0: Coil Objects=Coil_0 Conductor_number=26 Winding=PhaseA PolarityType=Positive
  PhARe_0: Coil Objects=CoilRe_5 Conductor_number=26 Winding=PhaseA PolarityType=Negative
  PhA_1: Coil Objects=Coil_1 Conductor_number=26 Winding=PhaseA PolarityType=Positive
  PhCRe_2: Coil Objects=Coil_2 Conductor_number=26 Winding=PhaseC PolarityType=Negative
  PhCRe_3: Coil Objects=Coil_3 Conductor_number=26 Winding=PhaseC PolarityType=Negative
  PhB_4: Coil Objects=Coil_4 Conductor_number=26 Winding=PhaseB PolarityType=Positive
  PhB_5: Coil Objects=Coil_5 Conductor_number=26 Winding=PhaseB PolarityType=Positive
  PhA_19: Coil Objects=CoilRe_0 Conductor_number=26 Winding=PhaseA PolarityType=Positive
  PhCRe_20: Coil Objects=CoilRe_1 Conductor_number=26 Winding=PhaseC PolarityType=Negative
  PhCRe_21: Coil Objects=CoilRe_2 Conductor_number=26 Winding=PhaseC PolarityType=Negative
  PhB_22: Coil Objects=CoilRe_3 Conductor_number=26 Winding=PhaseB PolarityType=Positive
  PhB_23: Coil Objects=CoilRe_4 Conductor_number=26 Winding=PhaseB PolarityType=Positive
  PhaseA: Winding Group Type=Current IsSolid=false Current=Ipk_a*cos(2*pi*f_e*time+elec_phase) ParallelBranchesNum=1
  PhaseB: Winding Group Type=Current IsSolid=false Current=Ipk*cos(2*pi*f_e*time+elec_phase-120deg) ParallelBranchesNum=1
  PhaseC: Winding Group Type=Current IsSolid=false Current=Ipk*cos(2*pi*f_e*time+elec_phase-240deg) ParallelBranchesNum=1
mesh:
  Length_Coil: LengthBased RefineInside Objects=[Coil_0..Coil_5, CoilRe_0..CoilRe_5] MaxLength=3mm
  Length_Mag: LengthBased RefineInside Objects=[Mag1_0, Mag2_0] MaxLength=3mm
  SurfApprox_Mag: SurfApproxBased Objects=[Mag1_0, Mag2_0] CurvedSurfaceApproxChoice=ManualSettings SurfDev=0.037mm NormalDev=15deg
  SurfApprox_Main: SurfApproxBased Objects=[Stator, Rotor, Band, OuterRegion, InnerRegion, Shaft] CurvedSurfaceApproxChoice=ManualSettings SurfDev=0.06mm NormalDev=15deg
  Length_Main: LengthBased RefineInside Objects=[Stator, Rotor, Band, OuterRegion, InnerRegion, Shaft] MaxLength=3mm
  Length1: LengthBased Edges=Rotor.edge(3 of 74, 4 of 74, 5 of 74, 6 of 74, 7 of 74, 8 of 74, 9 of 74, 10 of 74, 11 of 74, 12 of 74, 13 of 74, 14 of 74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) MaxLength=0.75mm
  initial mesh: MeshMethod=AnsoftTAU
setups:
  Setup1: Transient NonlinearSolverResidual=1e-05 StopTime=4/(2.5*f_e) TimeStep=1/f_e/200 SaveFieldsType=Custom SweepRanges{0ms to 32000000ns step 100000ns} NumberSolveSteps=1 RangeStart=0s RangeEnd=0.1s InitialTimeStep=0.002s MinTimeStep=0.001s MaxTimeStep=0.003s TimeStepErrTolerance=0.0001
output variables:
  pos = Moving1.Position * 2 - 13*PI/12
  cos0 = cos(pos)
  cos1 = cos(pos-2*PI/3)
  cos2 = cos(pos-4*PI/3)
  sin0 = sin(pos)
  sin1 = sin(pos-2*PI/3)
  sin2 = sin(pos-4*PI/3)
  Lad = L(PhaseA,PhaseA)*cos0 + L(PhaseA,PhaseB)*cos1 + L(PhaseA,PhaseC)*cos2
  Laq = L(PhaseA,PhaseA)*sin0 + L(PhaseA,PhaseB)*sin1 + L(PhaseA,PhaseC)*sin2
  Lbd = L(PhaseB,PhaseA)*cos0 + L(PhaseB,PhaseB)*cos1 + L(PhaseB,PhaseC)*cos2
  Lbq = L(PhaseB,PhaseA)*sin0 + L(PhaseB,PhaseB)*sin1 + L(PhaseB,PhaseC)*sin2
  Lcd = L(PhaseC,PhaseA)*cos0 + L(PhaseC,PhaseB)*cos1 + L(PhaseC,PhaseC)*cos2
  Lcq = L(PhaseC,PhaseA)*sin0 + L(PhaseC,PhaseB)*sin1 + L(PhaseC,PhaseC)*sin2
  L_d = (Lad*cos0 + Lbd*cos1 + Lcd*cos2) * 2/3
  L_q = (Laq*sin0 + Lbq*sin1 + Lcq*sin2) * 2/3
  Flux_d = FluxLinkage(PhaseA)*cos0 + FluxLinkage(PhaseB)*cos1 + FluxLinkage(PhaseC)*cos2
  Flux_q = FluxLinkage(PhaseA)*sin0 + FluxLinkage(PhaseB)*sin1 + FluxLinkage(PhaseC)*sin2
  I_d = InputCurrent(PhaseA)*cos0 + InputCurrent(PhaseB)*cos1 + InputCurrent(PhaseC)*cos2
  I_q = InputCurrent(PhaseA)*-sin0 + InputCurrent(PhaseB)*-sin1 + InputCurrent(PhaseC)*-sin2
field calculator expressions:
  Detection_circle_area = 1 | EnterSurface(Circle1) | SurfaceValue | Integrate
  B_1 = Fundamental_Quantity(22) | EnterCoord(ObjectCS1) | UnitVecCSX | Dot | EnterSurface(Circle1) | SurfaceValue | Integrate | Detection_circle_area | /
  H_1 = Fundamental_Quantity(21) | EnterCoord(ObjectCS1) | UnitVecCSX | Dot | EnterSurface(Circle1) | SurfaceValue | Integrate | Detection_circle_area | /
field plots:
  Mesh1: MeshPlots over a plane on Setup1 : Transient at Time=-1
  B_Vector1: B1 over Mag1_0 on Setup1 : Transient at Time=-1
  Mag_B1: B over Mag1_0, Circle1 on Setup1 : Transient at Time=-1
  Jz1: J over Coil_0..Coil_5, CoilRe_0..CoilRe_5 on Setup1 : Transient at Time=-1
  Flux_Lines1: A over Band, Shaft, OuterRegion, Stator, Coil_0..Coil_5, CoilRe_0..CoilRe_5, Rotor, Mag1_0, Mag2_0, InnerRegion, Circle1 on Setup1 : Transient at Time=-1
reports:
  Stator Currents: InputCurrent(PhaseA), InputCurrent(PhaseB), InputCurrent(PhaseC) vs Time on Setup1 : Transient; markers m1 at 3.8888968ms
  Moving Torque: Moving1.Torque vs Time on Setup1 : Transient [elec_phase=all]
  L_dq: L_d, L_q vs Time on Setup1 : Transient
  Flux_dq: Flux_d, Flux_q vs Time on Setup1 : Transient
  I_dq: I_d, I_q vs Time on Setup1 : Transient
  Recoil_curve: B(teslas) vs H(A/m); B_1 vs H_1 on Setup1 : Transient [Time=all]
